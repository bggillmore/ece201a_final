// Design: ajgrosze_scratch/single_inv_sim
simulator lang=spectre
global 0
parameters vdc=1.2
include "/misc/scratch/ajgrosze/lpr/schematics/models/32nm_LP.pm"

// ajgrosze_scratch/inv/schematic
subckt inv in out vdd
    M0 (out in 0 0) nmos w=128n l=32n
    M1 (out in vdd vdd) pmos w=256n l=32n
ends inv

// ajgrosze_scratch/single_inv_sim/schematic
I0 (net5 vout net3) inv
V1 (net3 0) vsource dc=vdc type=dc
V0 (net5 0) vsource dc=0 type=dc
simulatorOptions options temp=27
dcOp dc
dc dc param=vdc start=0 stop=1.2 step=0.01
save I0.M0:s vout I0:1 I0:2 I0:3
