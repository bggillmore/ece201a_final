// Design: ECE_6240_Digial/hw2_2_XNOR_tb
simulator lang=spectre
global 0 vdd!
parameters p5vonly=0
include "/apps/design_kits/ncsu-cdk-1.6.0.beta/models/spectre/nom/ami06N.m"
include "/apps/design_kits/ncsu-cdk-1.6.0.beta/models/spectre/nom/ami06P.m"

// ECE_6240_Digial/hw1_3_CMOS_2_Input_NOR/schematic
subckt hw1_3_CMOS_2_Input_NOR A B Out
    N1 (Out B 0 0) ami06N w=1.5u l=600n m=1 region=sat
    N0 (Out A 0 0) ami06N w=1.5u l=600n m=1 region=sat
    P0 (net2 A vdd! vdd!) ami06P w=1.5u l=600n m=1 region=sat
    P1 (Out B net2 vdd!) ami06P w=1.5u l=600n m=1 region=sat
ends hw1_3_CMOS_2_Input_NOR

// ECE_6240_Digial/hw2_2_XNOR/schematic
subckt hw2_2_XNOR A B Out
    I3 (net9 net8 Out) hw1_3_CMOS_2_Input_NOR
    I2 (net7 B net8) hw1_3_CMOS_2_Input_NOR
    I1 (A net7 net9) hw1_3_CMOS_2_Input_NOR
    I0 (A B net7) hw1_3_CMOS_2_Input_NOR
ends hw2_2_XNOR

// ECE_6240_Digial/hw2_2_XNOR_tb/schematic
V0 (vdd! 0) vsource type=dc dc=5
I7 (A B Out) hw2_2_XNOR
C0 (Out 0) capacitor c=4p m=1
V1 (A 0) vsource type=pulse val0=0 val1=5 period=50u delay=0 rise=500f fall=500f width=25u
V2 (B 0) vsource type=pulse val0=0 val1=5 period=100u delay=0 rise=500f fall=500f width=50u
simulatorOptions options temp=27 tnom=25
tran tran stop=200u
