// Design: sigmadelta_local/test_i_diff_i_diff
simulator lang=spectre
global 0
include "/home/ic5.1/tools/dfII/samples/artist/ahdlLib/quantity.spectre"
parameters gb=0.9738 ga=0.9986 w2=10e-6 w1=15e-6 Vsupp=5 voutdc=2.25 vout=0 v_bpol=3 r=1510 per_tr=1e-8 l2=0.35e-6 l1=0.35e-6 Isin=0.001 Imin=0 Imax=0 iindc=0.0001 Iin=0 i2=1.7e-3 i1=3.9e-3 g4=0 g3=0 g2=-1 g1=1 ar=9.6
include "/home/AMS_3.70/spectre/s35/mcparams.scs"
include "/home/AMS_3.70/spectre/s35/cmos53.scs" section=cmostm
include "/home/AMS_3.70/spectre/s35/res.scs" section=restm
include "/home/AMS_3.70/spectre/s35/cap.scs" section=captm
include "/home/AMS_3.70/spectre/s35/vbic.scs" section=biptm
include "/home/AMS_3.70/spectre/s35/ind.scs" section=indtm

// sigmadelta_local/simect_i_diff_i_diff_sch/schematic
subckt simect_i_diff_i_diff_sch Iin\+ Iin\- Iout\+ Iout\- Vsupp gnd
    I0 (Vsupp net35) isource dc=i1-i2 type=dc
    I1 (Vsupp net85) isource dc=i1-i2 type=dc
    I2 (Iin\+ gnd) isource dc=i1 type=dc
    I3 (Iin\- gnd) isource dc=i1 type=dc
    MP12 (Iout\+ net86 Vsupp Vsupp) modp w=w1*ga*(2-gb) l=l1 ng=1
    MP11 (net85 net85 Vsupp Vsupp) modp w=2*w1 l=l1 ng=1
    MP1 (net35 net35 Vsupp Vsupp) modp w=2*w1 l=l1 ng=1
    MP10 (net59 net85 Vsupp Vsupp) modp w=w1 l=l1 ng=1
    MP0 (Iout\- net88 Vsupp Vsupp) modp w=w1*ga*(2-gb) l=l1 ng=1
    MP9 (net76 net35 Vsupp Vsupp) modp w=w1 l=l1 ng=1
    Q0 (net35 net79 Iin\+ gnd) npn143h5 area=ar m=1
    Q1 (net85 net49 Iin\- gnd) npn143h5 area=ar m=1
    MN8 (Iout\- net59 gnd gnd) modn w=w2*ga*gb l=l2 ng=1
    MN7 (net59 net59 gnd gnd) modn w=w2 l=l2 ng=1
    MN2 (Iout\+ net76 gnd gnd) modn w=w2*ga*gb l=l2 ng=1
    MN6 (net76 net76 gnd gnd) modn w=w2 l=l2 ng=1
    V2 (net79 gnd) vsource dc=v_bpol type=dc
    V7 (net49 gnd) vsource dc=v_bpol type=dc
    R1 (net85 net86) resistor r=r
    R0 (net88 net35) resistor r=r
ends simect_i_diff_i_diff_sch

// sigmadelta_local/test_i_diff_i_diff/schematic
V4 (net025 0) vsource type=sine ampl=Isin freq=1/per_tr
I39 (Vin1 Vin2 Vout1 Vout2 net0106 0) simect_i_diff_i_diff_sch
V3 (net036 net025) vsource dc=Iin mag=1 type=pulse val0=Imin val1=Imax period=per_tr width=per_tr/2
G0 (0 net034 net036 0) vccs gm=g1
G1 (0 net028 net036 0) vccs gm=g2
I0 (0 net011) isource dc=iindc type=dc
E2 (Vout2 net055 net012 0) vcvs gain=g4
E1 (Vout1 net055 net012 0) vcvs gain=g3
F5 (0 net028) cccs gain=1 probe=V14
V1 (Vin1 net034) vsource dc=0 type=dc
V2 (Vin2 net028) vsource dc=0 type=dc
V9 (net055 0) vsource dc=voutdc type=dc
V10 (net012 0) vsource dc=vout mag=1 type=dc
V0 (net0106 0) vsource dc=Vsupp type=dc
V14 (net034 net011) vsource dc=0 type=dc
simulatorOptions options reltol=100e-6 temp=27 homotopy=all limit=delta compatible=spice2
tran tran stop=100n errpreset=conservative
save E2:p E1:p V2:p V1:p
