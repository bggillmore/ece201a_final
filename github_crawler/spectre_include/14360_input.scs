// Design: ee315_wrk/example_pss
simulator lang=spectre
global 0
parameters Cl=1p N=10 Ts=1n
include "/afs/ir.stanford.edu/class/ee315/models/ee315.mod"

// ee315_wrk/example_pss/schematic
V1 (clk 0) vsource type=pulse val0=0 val1=1 period=Ts delay=Ts/2
V0 (in 0) vsource pacmag=1 type=dc
I2 (in net7 clk 0) relay vt1=499m vt2=501m ropen=1T rclosed=1m
R0 (net7 out) resistor r=(Ts/2)/(N*Cl)
C0 (out 0) capacitor c=Cl
simulatorOptions options temp=27
pss pss fund=1G harms=0 errpreset=moderate maxacfreq=200G
+ annotate=status
pac ( clk 0 ) pac crossingdirection=rise thresholdvalue=0.1
+ ptvtype=sampled start=1k stop=2G lin=100 maxsideband=0
+ annotate=status
