// Design: ECE_6240_Digial/hw1_3_CMOS_3_Input_NAND_tb
simulator lang=spectre
global 0 vdd!
parameters p5vonly=0
include "/apps/design_kits/ncsu-cdk-1.6.0.beta/models/spectre/nom/ami06N.m"
include "/apps/design_kits/ncsu-cdk-1.6.0.beta/models/spectre/nom/ami06P.m"

// ECE_6240_Digial/hw1_3_CMOS_3_Input_NAND/schematic
subckt hw1_3_CMOS_3_Input_NAND A B C Out
    P0 (Out A vdd! vdd!) ami06P w=1.5u l=600n m=1 region=sat
    P1 (Out B vdd! vdd!) ami06P w=1.5u l=600n m=1 region=sat
    P2 (Out C vdd! vdd!) ami06P w=1.5u l=600n m=1 region=sat
    N2 (net20 C 0 0) ami06N w=1.5u l=600n m=1 region=sat
    N1 (net19 B net20 0) ami06N w=1.5u l=600n m=1 region=sat
    N0 (Out A net19 0) ami06N w=1.5u l=600n m=1 region=sat
ends hw1_3_CMOS_3_Input_NAND

// ECE_6240_Digial/hw1_3_CMOS_3_Input_NAND_tb/schematic
V0 (vdd! 0) vsource type=dc dc=5
V3 (C 0) vsource type=pulse dc=5 val0=0 val1=5 period=200u delay=0 rise=500f fall=500f width=100u
V2 (A 0) vsource type=pulse dc=5 val0=0 val1=5 period=50u delay=0 rise=500f fall=500f width=25u
V1 (B 0) vsource type=pulse dc=5 val0=0 val1=5 period=100u delay=0 rise=500f fall=500f width=50u
C0 (Out 0) capacitor c=4p m=1
I12 (A B C Out) hw1_3_CMOS_3_Input_NAND
simulatorOptions options temp=27 tnom=25
tran tran stop=250u
