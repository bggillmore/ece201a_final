// Design: ECE_6240_Digital/hw3_2_dynamic_cmos_4_tb
simulator lang=spectre
global 0 gnda! vdd!
parameters p5vonly=0
include "/apps/design_kits/ncsu-cdk-1.6.0.beta/models/spectre/nom/ami06N.m"
include "/apps/design_kits/ncsu-cdk-1.6.0.beta/models/spectre/nom/ami06P.m"

// ECE_6240_Digital/hw3_2_dynamic_cmos_4/schematic
subckt hw3_2_dynamic_cmos_4 A B C Clk D G
    N4 (net9 Clk gnda! gnda!) ami06N w=1.5u l=600n m=1 region=sat
    N3 (G D net9 net9) ami06N w=1.5u l=600n m=1 region=sat
    N2 (G C net9 net9) ami06N w=1.5u l=600n m=1 region=sat
    N1 (G B net9 net9) ami06N w=1.5u l=600n m=1 region=sat
    N0 (G A net9 net9) ami06N w=1.5u l=600n m=1 region=sat
    P0 (G Clk vdd! vdd!) ami06P w=1.5u l=600n m=1 region=sat
ends hw3_2_dynamic_cmos_4

// ECE_6240_Digital/hw3_2_dynamic_cmos_4_tb/schematic
V0 (vdd! 0) vsource type=dc dc=5
V5 (D 0) vsource type=pulse dc=5 val0=0 val1=5 period=160u delay=0 rise=500f fall=500f width=80u
V4 (Clk 0) vsource type=pulse dc=5 val0=0 val1=5 period=320u delay=0 rise=500f fall=500f width=160u
V3 (C 0) vsource type=pulse dc=5 val0=0 val1=5 period=80u delay=0 rise=500f fall=500f width=40u
V2 (B 0) vsource type=pulse dc=5 val0=0 val1=5 period=40u delay=0 rise=500f fall=500f width=20u
V1 (A 0) vsource type=pulse dc=5 val0=0 val1=5 period=20u delay=0 rise=500f fall=500f width=10u
C0 (G 0) capacitor c=4p m=1
I13 (A B C Clk D G) hw3_2_dynamic_cmos_4
simulatorOptions options temp=27 tnom=25
tran tran stop=500u
