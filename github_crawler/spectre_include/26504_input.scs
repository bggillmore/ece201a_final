// Design: ee315_wrk/comparator_tb
simulator lang=spectre
global 0
parameters vdd=1.8 vic=0.9 vid=100m
include "/afs/ir.stanford.edu/class/ee315/models/ee315.mod"

// ee315/ideal_balun/schematic
subckt ideal_balun d c p n
    K0 (d 0 p c) transformer n1=2
    K1 (d 0 c n) transformer n1=2
ends ideal_balun

// ee315/comparator/schematic
subckt comparator str vdd vim vip vom vop vss inh_bulk_n
    I0 (net9 vss) isource dc=20u type=dc
    M0 (vom vip net9 inh_bulk_n) nmos w=3u l=0.18u
    M1 (vop vim net9 inh_bulk_n) nmos w=3u l=0.18u
    M2 (vop vom vdd vdd) pmos w=3u l=0.18u
    M3 (vom vop vdd vdd) pmos w=3u l=0.18u
    M4 (vop str vom vdd) pmos w=0.5u l=0.18u
    M5 (vom str vop vdd) pmos w=0.5u l=0.18u
ends comparator

// ee315_wrk/comparator_tb/schematic
V2 (vic 0) vsource dc=vic type=dc
V3 (vid 0) vsource dc=vid mag=0 type=dc
V0 (vdd 0) vsource dc=vdd type=dc
I4 (vid vic vip vim) ideal_balun
I7 (vod net012 vop vom) ideal_balun
V5 (str 0) vsource type=pwl wave=[ 5n 0 5.2n vdd ]
I3 (str vdd vim vip vom vop 0 0) comparator
simulatorOptions options temp=27
tran tran stop=15n errpreset=conservative
dcOp dc
capInfo_dc info what=captab where=rawfile threshold=0.0 detail=node sort=name
