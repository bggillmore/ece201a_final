// Generated for: spectre
// Generated on: Nov 13 17:36:05 2018
// Design library name: ECE_6240_Digial
// Design cell name: hw2_2_XNOR
// Design view name: extracted
simulator lang=spectre
global 0
parameters p5vonly=0
include "/apps/design_kits/ncsu-cdk-1.6.0.beta/models/spectre/nom/ami06N.m"
include "/apps/design_kits/ncsu-cdk-1.6.0.beta/models/spectre/nom/ami06P.m"

// Library name: ECE_6240_Digial
// Cell name: hw2_2_XNOR
// View name: extracted
\+8 (9 A vdd! vdd!) ami06P w=1.5e-06 l=6e-07 as=2.25e-12 ad=1.35e-12 \
        ps=4.5e-06 pd=1.8e-06 m=1 region=sat
\+9 (6 B 9 vdd!) ami06P w=1.5e-06 l=6e-07 as=1.35e-12 ad=2.25e-12 \
        ps=1.8e-06 pd=4.5e-06 m=1 region=sat
\+10 (10 A vdd! vdd!) ami06P w=1.5e-06 l=6e-07 as=2.25e-12 ad=1.35e-12 \
        ps=4.5e-06 pd=1.8e-06 m=1 region=sat
\+11 (7 6 10 vdd!) ami06P w=1.5e-06 l=6e-07 as=1.35e-12 ad=2.25e-12 \
        ps=1.8e-06 pd=4.5e-06 m=1 region=sat
\+12 (11 B vdd! vdd!) ami06P w=1.5e-06 l=6e-07 as=2.25e-12 ad=1.35e-12 \
        ps=4.5e-06 pd=1.8e-06 m=1 region=sat
\+13 (8 6 11 vdd!) ami06P w=1.5e-06 l=6e-07 as=1.35e-12 ad=2.25e-12 \
        ps=1.8e-06 pd=4.5e-06 m=1 region=sat
\+14 (12 7 vdd! vdd!) ami06P w=1.5e-06 l=6e-07 as=2.25e-12 ad=1.35e-12 \
        ps=4.5e-06 pd=1.8e-06 m=1 region=sat
\+15 (Out 8 12 vdd!) ami06P w=1.5e-06 l=6e-07 as=1.35e-12 ad=2.25e-12 \
        ps=1.8e-06 pd=4.5e-06 m=1 region=sat
\+52 (gnd! 8) capacitor c=1.20528e-15 m=1
\+51 (gnd! 7) capacitor c=1.20528e-15 m=1
\+50 (gnd! 6) capacitor c=2.41056e-15 m=1
\+49 (B gnd!) capacitor c=2.41056e-15 m=1
\+48 (A gnd!) capacitor c=2.41056e-15 m=1
\+47 (vdd! 8) capacitor c=1.3392e-16 m=1
\+46 (vdd! 7) capacitor c=1.3392e-16 m=1
\+45 (vdd! 6) capacitor c=2.6784e-16 m=1
\+44 (vdd! B) capacitor c=2.6784e-16 m=1
\+43 (vdd! A) capacitor c=2.6784e-16 m=1
\+42 (6 8) capacitor c=2.7e-16 m=1
\+41 (6 7) capacitor c=2.7e-16 m=1
\+40 (gnd! 8) capacitor c=4.44432e-15 m=1
\+39 (gnd! 7) capacitor c=4.44432e-15 m=1
\+38 (gnd! 6) capacitor c=4.77336e-15 m=1
\+37 (Out 8) capacitor c=2.7e-16 m=1
\+36 (Out gnd!) capacitor c=4.11528e-15 m=1
\+35 (B 6) capacitor c=2.7e-16 m=1
\+34 (B gnd!) capacitor c=6.5808e-16 m=1
\+33 (A gnd!) capacitor c=6.5808e-16 m=1
\+32 (vdd! 8) capacitor c=4.4736e-16 m=1
\+31 (vdd! 7) capacitor c=4.4736e-16 m=1
\+30 (vdd! 6) capacitor c=4.4736e-16 m=1
\+29 (vdd! Out) capacitor c=4.4736e-16 m=1
\+28 (7 8) capacitor c=5.028e-16 m=1
\+27 (6 8) capacitor c=3.1776e-16 m=1
\+26 (6 7) capacitor c=5.028e-16 m=1
\+25 (gnd! 8) capacitor c=1.48008e-15 m=1
\+24 (gnd! 7) capacitor c=1.38972e-15 m=1
\+23 (gnd! 6) capacitor c=1.93434e-15 m=1
\+22 (Out 8) capacitor c=3.1776e-16 m=1
\+21 (B 7) capacitor c=5.028e-16 m=1
\+20 (B 6) capacitor c=3.7008e-16 m=1
\+19 (B gnd!) capacitor c=1.42728e-15 m=1
\+18 (A 6) capacitor c=5.028e-16 m=1
\+17 (A gnd!) capacitor c=7.512e-16 m=1
\+16 (A B) capacitor c=3.7008e-16 m=1
\+0 (6 A gnd! gnd!) ami06N w=1.5e-06 l=6e-07 as=2.25e-12 ad=1.35e-12 \
        ps=4.5e-06 pd=1.8e-06 m=1 region=sat
\+1 (gnd! B 6 gnd!) ami06N w=1.5e-06 l=6e-07 as=1.35e-12 ad=2.25e-12 \
        ps=1.8e-06 pd=4.5e-06 m=1 region=sat
\+2 (7 A gnd! gnd!) ami06N w=1.5e-06 l=6e-07 as=2.25e-12 ad=1.35e-12 \
        ps=4.5e-06 pd=1.8e-06 m=1 region=sat
\+3 (gnd! 6 7 gnd!) ami06N w=1.5e-06 l=6e-07 as=1.35e-12 ad=2.25e-12 \
        ps=1.8e-06 pd=4.5e-06 m=1 region=sat
\+4 (8 B gnd! gnd!) ami06N w=1.5e-06 l=6e-07 as=2.25e-12 ad=1.35e-12 \
        ps=4.5e-06 pd=1.8e-06 m=1 region=sat
\+5 (gnd! 6 8 gnd!) ami06N w=1.5e-06 l=6e-07 as=1.35e-12 ad=2.25e-12 \
        ps=1.8e-06 pd=4.5e-06 m=1 region=sat
\+6 (Out 7 gnd! gnd!) ami06N w=1.5e-06 l=6e-07 as=2.25e-12 ad=1.35e-12 \
        ps=4.5e-06 pd=1.8e-06 m=1 region=sat
\+7 (gnd! 8 Out gnd!) ami06N w=1.5e-06 l=6e-07 as=1.35e-12 ad=2.25e-12 \
        ps=1.8e-06 pd=4.5e-06 m=1 region=sat
include "/home/seas/jwcrandall/cadence/simulation/hw2_2_XNOR/spectre/extracted/netlist/stimuli/stimulus.txt"
simulatorOptions options reltol=1e-3 vabstol=1e-6 iabstol=1e-12 temp=27 \
    tnom=25 scalem=1.0 scale=1.0 gmin=1e-12 rforce=1 maxnotes=5 maxwarns=5 \
    digits=5 cols=80 pivrel=1e-3 sensfile="../psf/sens.output" \
    checklimitdest=psf
tran tran stop=200u write="spectre.ic" writefinal="spectre.fc" \
    annotate=status maxiters=5
finalTimeOP info what=oppoint where=rawfile
modelParameter info what=models where=rawfile
element info what=inst where=rawfile
outputParameter info what=output where=rawfile
designParamVals info what=parameters where=rawfile
primitives info what=primitives where=rawfile
subckts info what=subckts where=rawfile
saveOptions options save=allpub
