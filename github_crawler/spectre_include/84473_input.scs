// Design: ajgrosze_scratch/nmos_3stack_sim
simulator lang=spectre
global 0 vss!
parameters vga=0 vgb=0 vgc=0
include "/misc/scratch/ajgrosze/lpr/schematics/models/32nm_LP.pm"

// ajgrosze_scratch/nmos_3stack_sim/schematic
Ma (net011 net06 net04 vss!) nmos w=320n l=32n
Mb (net07 net03 net011 vss!) nmos w=320n l=32n
Mc (vss! net010 net07 vss!) nmos w=320n l=32n
Vc (net010 vss!) vsource dc=vgc type=dc
Vb (net03 vss!) vsource dc=vgb type=dc
V0 (net04 vss!) vsource dc=1.2 type=dc
Va (net06 vss!) vsource dc=vga type=dc
simulatorOptions options temp=27
dcOp dc
save Mc:d
