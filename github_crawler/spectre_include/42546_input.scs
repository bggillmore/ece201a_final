// Design: hw3_p3/p3
simulator lang=spectre
global 0 vdd!
parameters vin=0
include "/afs/ir.stanford.edu/class/ee315/models/ee315.mod"
include "/afs/.ir.stanford.edu/users/l/e/lenius/ee315/cadence/opus/hw3_save_op.scs"

// hw3_p3/p3/schematic
MN (out vdd! in 0) nmos w=10u l=0.18u
V1 (in 0) vsource dc=vin type=dc
V0 (vdd! 0) vsource dc=1.8 type=dc
MP (out 0 in vdd!) pmos w=35.2u l=0.18u
simulatorOptions options temp=27
dcOp dc save=all print=yes
dc dc param=vin start=0 stop=1.8 save=all print=yes
save in out
saveOptions options save=all currents=all
