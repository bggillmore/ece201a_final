// Design: ajgrosze_scratch/nmos_stack_compare
simulator lang=spectre
global 0 vss!
parameters vgs=0
include "/home/ecelrc/students/agroszewski/lpr/schematics/models/32nm_LP.pm"

// ajgrosze_scratch/nmos_stack_compare/schematic
Mstack_top (net07 net03 net04 vss!) nmos w=320n l=32n
Mstack_bot (vss! net03 net07 vss!) nmos w=320n l=32n
Msingle (vss! net03 net04 vss!) nmos w=320n l=32n
V1 (net03 vss!) vsource dc=vgs type=dc
V0 (net04 vss!) vsource dc=1.2 type=dc
simulatorOptions options temp=27
dc dc param=vgs start=0 stop=1.2
save Msingle:d Mstack_bot:d Msingle:s Mstack_bot:s
