// Design: ECE_6240_Digital/hw3_1_mirror_adder_1bit_tb
simulator lang=spectre
global 0 vdd!
parameters p5vonly=0
include "/apps/design_kits/ncsu-cdk-1.6.0.beta/models/spectre/nom/ami06N.m"
include "/apps/design_kits/ncsu-cdk-1.6.0.beta/models/spectre/nom/ami06P.m"

// ECE_6240_Digital/hw1_1_c_inverter/schematic
subckt hw1_1_c_inverter VIN VOUT
    P0 (VOUT VIN vdd! vdd!) ami06P w=3u l=600n m=1 region=sat
    N0 (VOUT VIN 0 0) ami06N w=1.5u l=600n m=1 region=sat
ends hw1_1_c_inverter

// ECE_6240_Digital/hw3_1_mirror_adder_1bit/schematic
subckt hw3_1_mirror_adder_1bit A B Cin Cout S
    P11 (net32 net10 net35 vdd!) ami06P w=1.5u l=600n m=1 region=sat
    P10 (net10 A net24 vdd!) ami06P w=1.5u l=600n m=1 region=sat
    P9 (net10 Cin net11 vdd!) ami06P w=1.5u l=600n m=1 region=sat
    P8 (net25 B vdd! vdd!) ami06P w=1.5u l=600n m=1 region=sat
    P7 (net26 A net25 vdd!) ami06P w=1.5u l=600n m=1 region=sat
    P6 (net32 Cin net26 vdd!) ami06P w=1.5u l=600n m=1 region=sat
    P5 (net35 Cin vdd! vdd!) ami06P w=1.5u l=600n m=1 region=sat
    P4 (net35 B vdd! vdd!) ami06P w=1.5u l=600n m=1 region=sat
    P3 (net35 A vdd! vdd!) ami06P w=1.5u l=600n m=1 region=sat
    P2 (net24 B vdd! vdd!) ami06P w=1.5u l=600n m=1 region=sat
    P1 (net11 B vdd! vdd!) ami06P w=1.5u l=600n m=1 region=sat
    P0 (net11 A vdd! vdd!) ami06P w=1.5u l=600n m=1 region=sat
    N11 (net32 net10 net059 0) ami06N w=1.5u l=600n m=1 region=sat
    N10 (net022 B 0 0) ami06N w=1.5u l=600n m=1 region=sat
    N9 (net021 A net022 0) ami06N w=1.5u l=600n m=1 region=sat
    N8 (net32 Cin net021 0) ami06N w=1.5u l=600n m=1 region=sat
    N7 (net059 Cin 0 0) ami06N w=1.5u l=600n m=1 region=sat
    N6 (net059 B 0 0) ami06N w=1.5u l=600n m=1 region=sat
    N5 (net059 A 0 0) ami06N w=1.5u l=600n m=1 region=sat
    N4 (net10 A net23 0) ami06N w=1.5u l=600n m=1 region=sat
    N3 (net23 B 0 0) ami06N w=1.5u l=600n m=1 region=sat
    N2 (net9 B 0 0) ami06N w=1.5u l=600n m=1 region=sat
    N1 (net9 A 0 0) ami06N w=1.5u l=600n m=1 region=sat
    N0 (net10 Cin net9 0) ami06N w=1.5u l=600n m=1 region=sat
    I3 (net32 S) hw1_1_c_inverter
    I2 (net10 Cout) hw1_1_c_inverter
ends hw3_1_mirror_adder_1bit

// ECE_6240_Digital/hw3_1_mirror_adder_1bit_tb/schematic
V0 (vdd! 0) vsource type=dc dc=5
V3 (Cin 0) vsource type=pulse dc=5 val0=0 val1=5 period=200u delay=0 rise=500f fall=500f width=100u
V2 (A 0) vsource type=pulse dc=5 val0=0 val1=5 period=50u delay=0 rise=500f fall=500f width=25u
V1 (B 0) vsource type=pulse dc=5 val0=0 val1=5 period=100u delay=0 rise=500f fall=500f width=50u
C1 (Sum 0) capacitor c=4p m=1
C0 (Cout 0) capacitor c=4p m=1
I16 (A B Cin Cout Sum) hw3_1_mirror_adder_1bit
simulatorOptions options temp=27 tnom=25
tran tran stop=250u
