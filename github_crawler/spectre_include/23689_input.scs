// Design: ajgrosze_scratch/pmos_vth
simulator lang=spectre
global 0
parameters len=32n vds_sweep=-1.2 Vbsweep=0 Vsweep=1
include "/home/ecelrc/students/agroszewski/lpr/schematics/models/32nm_LP.pm"

// ajgrosze_scratch/pmos_vth/schematic
M0 (net03 Vg 0 net07) pmos w=320.00n l=len
V1 (net07 0) vsource dc=Vbsweep type=dc
Vds (net03 0) vsource dc=vds_sweep type=dc
include "./_graphical_stimuli.scs"
simulatorOptions options temp=27
dcOp dc
dc dc param=Vsweep start=0 stop=-1.2
save M0:s M0:d
