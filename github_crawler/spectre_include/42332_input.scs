// Generated for: spectre
// Generated on: Feb 24 13:16:10 2023
// Design library name: Design
// Design cell name: inverter_schematic
// Design view name: schematic
simulator lang=spectre
global 0 vdd!
include "/home/ugrads/h/hbritton/cadence/models/spectre/tsmc20P.m"
include "/home/ugrads/h/hbritton/cadence/models/spectre/tsmc20N.m"

// Library name: Design
// Cell name: inverter
// View name: extracted
// View type: maskLayout
subckt inverter_extracted GND VDD in out
    \+1 (out in VDD VDD) tsmc20P w=9e-07 l=2e-07 as=4.5e-13 ad=4.5e-13 \
        ps=1.9e-06 pd=1.9e-06 m=1 region=sat
    \+0 (out in GND GND) tsmc20N w=3e-07 l=2e-07 as=1.9e-13 ad=1.9e-13 \
        ps=1.5e-06 pd=1.5e-06 m=1 region=sat
ends inverter_extracted
// End of subcircuit definition.

// Library name: Design
// Cell name: inverter_schematic
// View name: schematic
I0 (0 vdd! in out) inverter_extracted
V0 (vdd! 0) vsource type=dc dc=1.8
V1 (in 0) vsource type=pulse dc=1.8 val0=0 val1=1.8 period=12n delay=3n \
        rise=100p fall=100p width=5n
C0 (out 0) capacitor c=50f m=1
simulatorOptions options psfversion="1.1.0" reltol=1e-3 vabstol=1e-6 \
    iabstol=1e-12 temp=27 tnom=27 scalem=1.0 scale=1.0 gmin=1e-12 rforce=1 \
    maxnotes=5 maxwarns=5 digits=5 cols=80 pivrel=1e-3 \
    sensfile="../psf/sens.output" checklimitdest=psf
tran tran stop=30n write="spectre.ic" writefinal="spectre.fc" \
    annotate=status maxiters=5
finalTimeOP info what=oppoint where=rawfile
modelParameter info what=models where=rawfile
element info what=inst where=rawfile
outputParameter info what=output where=rawfile
designParamVals info what=parameters where=rawfile
primitives info what=primitives where=rawfile
subckts info what=subckts where=rawfile
save out in
saveOptions options save=allpub
