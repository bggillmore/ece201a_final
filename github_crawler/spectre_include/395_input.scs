// Design: example/rc_lpf
simulator lang=spectre
global 0
parameters V=0 vdc=1
include "/afs/ir.stanford.edu/class/ee315/models/ee315.mod"

// example/rc_lpf/schematic
R0 (in out) resistor r=500K
C0 (out 0) capacitor c=10p
V0 (in 0) vsource dc=vdc mag=1V type=dc
simulatorOptions options temp=27
ac ac start=1 stop=100G
