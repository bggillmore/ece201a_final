// Generated for: spectre
// Generated on: Nov 13 16:05:38 2018
// Design library name: ECE_6240_Digial
// Design cell name: hw2_2_XOR
// Design view name: extracted
simulator lang=spectre
global 0
parameters p5vonly=0
include "/apps/design_kits/ncsu-cdk-1.6.0.beta/models/spectre/nom/ami06N.m"
include "/apps/design_kits/ncsu-cdk-1.6.0.beta/models/spectre/nom/ami06P.m"

// Library name: ECE_6240_Digial
// Cell name: hw2_2_XOR
// View name: extracted
\+15 (vdd! Out Out vdd!) ami06P w=1.5e-06 l=6e-07 as=1.35e-12 ad=2.25e-12 \
        ps=1.8e-06 pd=4.5e-06 m=1 region=sat
\+14 (Out 9 vdd! vdd!) ami06P w=1.5e-06 l=6e-07 as=2.25e-12 ad=1.35e-12 \
        ps=4.5e-06 pd=1.8e-06 m=1 region=sat
\+13 (vdd! 7 Out vdd!) ami06P w=1.5e-06 l=6e-07 as=1.35e-12 ad=2.25e-12 \
        ps=1.8e-06 pd=4.5e-06 m=1 region=sat
\+12 (Out B vdd! vdd!) ami06P w=1.5e-06 l=6e-07 as=2.25e-12 ad=1.35e-12 \
        ps=4.5e-06 pd=1.8e-06 m=1 region=sat
\+11 (vdd! 7 9 vdd!) ami06P w=1.5e-06 l=6e-07 as=1.35e-12 ad=2.25e-12 \
        ps=1.8e-06 pd=4.5e-06 m=1 region=sat
\+10 (9 A vdd! vdd!) ami06P w=1.5e-06 l=6e-07 as=2.25e-12 ad=1.35e-12 \
        ps=4.5e-06 pd=1.8e-06 m=1 region=sat
\+9 (vdd! B 7 vdd!) ami06P w=1.5e-06 l=6e-07 as=1.35e-12 ad=2.25e-12 \
        ps=1.8e-06 pd=4.5e-06 m=1 region=sat
\+8 (7 A vdd! vdd!) ami06P w=1.5e-06 l=6e-07 as=2.25e-12 ad=1.35e-12 \
        ps=4.5e-06 pd=1.8e-06 m=1 region=sat
\+48 (gnd! 9) capacitor c=1.20528e-15 m=1
\+47 (gnd! 7) capacitor c=2.41056e-15 m=1
\+46 (Out gnd!) capacitor c=1.20528e-15 m=1
\+45 (B gnd!) capacitor c=2.41056e-15 m=1
\+44 (A gnd!) capacitor c=2.41056e-15 m=1
\+43 (vdd! 9) capacitor c=1.3392e-16 m=1
\+42 (vdd! 7) capacitor c=2.6784e-16 m=1
\+41 (vdd! Out) capacitor c=1.3392e-16 m=1
\+40 (vdd! B) capacitor c=2.6784e-16 m=1
\+39 (vdd! A) capacitor c=2.6784e-16 m=1
\+38 (7 9) capacitor c=2.7e-16 m=1
\+37 (gnd! 9) capacitor c=4.44432e-15 m=1
\+36 (gnd! 7) capacitor c=5.52582e-15 m=1
\+35 (Out 7) capacitor c=2.7e-16 m=1
\+34 (Out gnd!) capacitor c=8.3748e-15 m=1
\+33 (B 7) capacitor c=2.7e-16 m=1
\+32 (B gnd!) capacitor c=6.5808e-16 m=1
\+31 (A gnd!) capacitor c=6.5808e-16 m=1
\+30 (vdd! 9) capacitor c=4.4736e-16 m=1
\+29 (vdd! 7) capacitor c=4.4736e-16 m=1
\+28 (vdd! Out) capacitor c=8.9472e-16 m=1
\+27 (7 9) capacitor c=5.028e-16 m=1
\+26 (gnd! 9) capacitor c=1.38972e-15 m=1
\+25 (gnd! 7) capacitor c=1.93434e-15 m=1
\+24 (Out 9) capacitor c=5.028e-16 m=1
\+23 (Out 7) capacitor c=5.028e-16 m=1
\+22 (Out gnd!) capacitor c=9.39e-16 m=1
\+21 (B 9) capacitor c=5.028e-16 m=1
\+20 (B 7) capacitor c=6.8784e-16 m=1
\+19 (B gnd!) capacitor c=1.27704e-15 m=1
\+18 (A 7) capacitor c=5.028e-16 m=1
\+17 (A gnd!) capacitor c=7.512e-16 m=1
\+16 (A B) capacitor c=3.7008e-16 m=1
\+7 (Out Out 11 gnd!) ami06N w=1.5e-06 l=6e-07 as=1.35e-12 ad=2.25e-12 \
        ps=1.8e-06 pd=4.5e-06 m=1 region=sat
\+6 (11 9 gnd! gnd!) ami06N w=1.5e-06 l=6e-07 as=2.25e-12 ad=1.35e-12 \
        ps=4.5e-06 pd=1.8e-06 m=1 region=sat
\+5 (Out 7 10 gnd!) ami06N w=1.5e-06 l=6e-07 as=1.35e-12 ad=2.25e-12 \
        ps=1.8e-06 pd=4.5e-06 m=1 region=sat
\+4 (10 B gnd! gnd!) ami06N w=1.5e-06 l=6e-07 as=2.25e-12 ad=1.35e-12 \
        ps=4.5e-06 pd=1.8e-06 m=1 region=sat
\+3 (9 7 8 gnd!) ami06N w=1.5e-06 l=6e-07 as=1.35e-12 ad=2.25e-12 \
        ps=1.8e-06 pd=4.5e-06 m=1 region=sat
\+2 (8 A gnd! gnd!) ami06N w=1.5e-06 l=6e-07 as=2.25e-12 ad=1.35e-12 \
        ps=4.5e-06 pd=1.8e-06 m=1 region=sat
\+1 (7 B 6 gnd!) ami06N w=1.5e-06 l=6e-07 as=1.35e-12 ad=2.25e-12 \
        ps=1.8e-06 pd=4.5e-06 m=1 region=sat
\+0 (6 A gnd! gnd!) ami06N w=1.5e-06 l=6e-07 as=2.25e-12 ad=1.35e-12 \
        ps=4.5e-06 pd=1.8e-06 m=1 region=sat
include "/home/seas/jwcrandall/cadence/simulation/hw2_2_XOR/spectre/extracted/netlist/stimuli/test.txt"
simulatorOptions options reltol=1e-3 vabstol=1e-6 iabstol=1e-12 temp=27 \
    tnom=25 scalem=1.0 scale=1.0 gmin=1e-12 rforce=1 maxnotes=5 maxwarns=5 \
    digits=5 cols=80 pivrel=1e-3 sensfile="../psf/sens.output" \
    checklimitdest=psf
tran tran stop=200u write="spectre.ic" writefinal="spectre.fc" \
    annotate=status maxiters=5
finalTimeOP info what=oppoint where=rawfile
modelParameter info what=models where=rawfile
element info what=inst where=rawfile
outputParameter info what=output where=rawfile
designParamVals info what=parameters where=rawfile
primitives info what=primitives where=rawfile
subckts info what=subckts where=rawfile
saveOptions options save=allpub
