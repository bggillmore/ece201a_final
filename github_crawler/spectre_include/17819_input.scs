// Design: ajgrosze_scratch/nmos_vth
simulator lang=spectre
global 0
parameters len=32n vds_sweep=1.2 vbsweep=0 Vsweep=1
include "/home/ecelrc/students/agroszewski/lpr/schematics/models/32nm_LP.pm"

// ajgrosze_scratch/nmos_vth/schematic
M0 (net3 Vin 0 net03) nmos w=320.00n l=len
Vbs (net03 0) vsource dc=vbsweep type=dc
Vds (net3 0) vsource dc=vds_sweep type=dc
include "./_graphical_stimuli.scs"
simulatorOptions options temp=27
dcOp dc
dc dc param=Vsweep start=0 stop=1.0
save M0:d
