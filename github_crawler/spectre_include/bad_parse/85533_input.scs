// Design: CMOSinverter_001/CMOSinverter_Simulation
simulator lang=spectre
global 0 vdd!
parameters _gpar0
include "/home/work/gpdk090_v4.6/libs.oa22/gpdk090/../../models/spectre/gpdk090.scs" section=NN
include "/home/work/gpdk045_v_5_0/gpdk045/../models/spectre/gpdk045.scs" section=mc

// CMOSinverter_001/CMOSinverter/schematic
subckt CMOSinverter GND VDD Vin Vout
    FirstINV (Vout Vin GND GND) gpdk090_nmos1v w=(120n) l=100n m=(1)*(1) simM=(1)*(1)
    FirstPMOS (Vout Vin VDD VDD) gpdk090_pmos1v w=(120n) l=100n m=(1)*(1) simM=(1)*(1)
ends CMOSinverter

// CMOSinverter_001/CMOSinverter_Simulation/schematic
I0 (0 vdd! Vin Vout) CMOSinverter
V0 (vdd! 0) vsource dc=1 type=dc
V1 (Vin 0) vsource type=pulse val0=1 val1=0 period=20n rise=50p fall=_gpar0 width=10n
simulatorOptions options temp=27
tran tran stop=100n errpreset=moderate
dcOp dc
dc dc dev=V1 param=dc start=0 stop=1
save I0:2
